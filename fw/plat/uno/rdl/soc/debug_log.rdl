// Copyright (c) Microsoft Corporation.
// Licensed under the MIT License.
//
// CP1 (HSM) debug log ring buffer in GSRAM.
//
// The HSM writes structured log entries into this producer-consumer
// ring. The SP drains it, folds the records into its own debug log,
// and flushes them to flash for `debuglogread` retrieval. This is the
// only logging path that is observable on a production blade — the
// semihosting and UART trace backends both require physical or
// emulator access.
//
// Protocol (SimplexPipe, matching the reference CP firmware):
//   - HSM owns the producer index (TAIL / PI) — advances after write.
//   - SP owns the consumer index (HEAD / CI) — advances after read.
//   - Ring is full when next_pi == ci (one slot is always left unused).
//   - A DMB between the entry write and the PI advance guarantees the
//     SP observes a complete entry before it observes the new index.
//
// Each entry is a 12-byte `DebugLogEntryParameters`:
//   severity(u8) | component(u8) | msg_index(u8) | _rsvd(u8) | arg1(u32) | arg2(u32)
//
// Layout (offsets from base 0x6100_27F8):
//   0x000 - 0x003   RING_BUFFER_SIZE   (depth, written by sender at init)
//   0x004 - 0x007   RING_BUFFER_HEAD   (CI — consumer index, owned by SP)
//   0x008 - 0x00B   RING_BUFFER_TAIL   (PI — producer index, owned by HSM)
//   0x00C - 0x00F   SENDER_OVERFLOWS   (overflow counter)
//   0x010 - 0x807   QUEUE[0..0xA9]     (0xAA entries x 12 B = 0x7F8 B)
//
// Total region size: 0x808 (2056 B).
//
// The base address and the 0xAA depth are a fixed cross-processor
// contract and must not be changed:
//   - SP   : sp/src/dc_scm/mem_map/gsram_mem_map.h
//            (GSRAM_MEM_MAP_CP1_DEBUG_LOG_*), and
//            sp/src/dc_scm/init/init_log_flush_handlers.c, which
//            registers the collector with CP_LOG_COLLECTOR_EXPECTED_
//            RECORDS = 170 (0xAA).
//   - CP V1: cp/hsm/mem-map/src/gsram.rs (cp1_debug_log_* fields).
//
// This region sits in the GSRAM gap between the SP-populated seed
// table (ends 0x135C) and BOOT_STATUS (0x7000), so it does not
// overlap any io_gsram allocation.

reg debug_log_ring_buffer_size_t {
    name = "Ring Buffer Size";
    desc = "Number of entries in the queue array. Written once by the
            HSM sender during initialization so the SP knows the ring
            depth. Must be written before the first send().";

    field {
        sw = rw;
        hw = r;
        desc = "Queue depth in entries (0xAA).";
    } SIZE[31:0] = 0x0;
};

reg debug_log_ring_buffer_head_t {
    name = "Ring Buffer Head (CI)";
    desc = "Consumer index. Owned by the SP, which advances it after
            reading an entry. The HSM reads it (volatile) to test
            whether the ring is full (next_pi == ci).";

    field {
        sw = rw;
        hw = rw;
        desc = "Consumer index (entry number, 0-based, wraps at depth).";
    } CI[31:0] = 0x0;
};

reg debug_log_ring_buffer_tail_t {
    name = "Ring Buffer Tail (PI)";
    desc = "Producer index. Owned by the HSM, which advances it after
            writing an entry (with a DMB before the advance). The SP
            reads it (volatile) to detect new entries (pi != ci).";

    field {
        sw = rw;
        hw = r;
        desc = "Producer index (entry number, 0-based, wraps at depth).";
    } PI[31:0] = 0x0;
};

reg debug_log_sender_overflows_t {
    name = "Sender Overflows";
    desc = "Monotonically increasing count of send attempts that were
            dropped because the ring was full. Written by the HSM, read
            by the SP to raise overflow diagnostics. A non-zero value
            means log records were lost.";

    field {
        sw = rw;
        hw = r;
        desc = "Dropped-record count.";
    } COUNT[31:0] = 0x0;
};

reg debug_log_dword_t {
    name = "Debug Log DWORD";
    desc = "One DWORD of a debug log entry.";
    field {} VAL[31:0] = 0x0;
};

// One debug log entry = 3 DWORDs (12 bytes):
//   DW0: severity(u8) | component(u8) | msg_index(u8) | _reserved(u8)
//   DW1: arg1 (u32)
//   DW2: arg2 (u32)
regfile debug_log_entry_t {
    name = "Debug Log Entry";
    desc = "One 12-byte DebugLogEntryParameters record. The layout
            matches the Cerberus C struct `debug_log_entry_parameters`
            and the reference Rust `mcr_types::DebugLogEntryParameters`
            byte for byte.";

    debug_log_dword_t HEADER @ 0x00;   // severity | component | msg_index | _rsvd
    debug_log_dword_t ARG1   @ 0x04;
    debug_log_dword_t ARG2   @ 0x08;
};

addrmap debug_log {
    name = "Debug Log GSRAM";
    desc = "CP1 (HSM) debug log ring buffer in GSRAM. The HSM produces
             records and the SP consumes them, using a SimplexPipe
             protocol. Entries are 12-byte DebugLogEntryParameters
             records.

             Ring depth: 0xAA entries (170 decimal).
             Entry size: 12 bytes (3 DWORDs).
             Ring data:  0xAA x 12 = 2040 bytes (0x7F8).
             Metadata:   16 bytes (size + head + tail + overflows).
             Total:      2056 bytes (0x808).";

    default hw = na;
    default sw = rw;

    debug_log_ring_buffer_size_t RING_BUFFER_SIZE @ 0x000;
    debug_log_ring_buffer_head_t RING_BUFFER_HEAD @ 0x004;
    debug_log_ring_buffer_tail_t RING_BUFFER_TAIL @ 0x008;
    debug_log_sender_overflows_t SENDER_OVERFLOWS @ 0x00C;

    // 0xAA entries x 12 B stride = 0x7F8 B
    debug_log_entry_t            QUEUE[170]       @ 0x010 += 0x0C;
};
